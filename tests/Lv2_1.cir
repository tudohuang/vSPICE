* LV2-1 Two Voltage Sources
V1 N1 0 DC 10
V2 N2 0 DC 3
R1 N1 N2 1k
R2 N2 0 2k
.OP
.END
