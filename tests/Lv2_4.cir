* LV2-4 Singular Circuit
V1 N1 N2 DC 5
R1 N1 N2 1k
.OP
.END
