* LV3-2 RC Low Pass
V1 IN 0 DC 0 AC 1
R1 IN OUT 1k
C1 OUT 0 1u
.AC DEC 10 10 100000
.END
